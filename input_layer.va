`include "constants.vams"
`include "disciplines.vams"

module crossbararray(gnd,out);

    parameter integer N = 49;
    output [0:48] out;
electrical[0:48]  out;

   inout gnd;
electrical gnd;
    integer i;
    integer filehandle;
    integer read_size;
    real stored_data[0:N-1];
genvar j;

    analog initial begin
        filehandle = $fopen("/home/work/inputdata.txt", "r");

        if (filehandle == 0) begin
            $display("ERROR: could not open file");
        end

        for (i = 0; i < N; i = i + 1) begin
            read_size = $fscanf(filehandle, "%f", stored_data[i]);
            $display("index %d  value = %g", i, stored_data[i]);
        end

        $fclose(filehandle);
    end

    analog begin
   for(j=0;j<N;j=j+1) begin
V(out[j])<+stored_data[j];
end
    end

endmodule
